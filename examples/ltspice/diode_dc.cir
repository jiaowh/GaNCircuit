* Known answer: I = IS*(exp(V/(kT/q))-1), IS = 1e-12 A, N = 1, T = 300 K
V1 anode 0 0
D1 anode 0 research_diode
.model research_diode D(IS=1e-12 N=1)
.temp 26.85
.options tnom=26.85 gmin=1e-18
.dc V1 0 0.5 0.05
.end
