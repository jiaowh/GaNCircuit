* Known answer: v(out) = 2 V * 1k/(1k+1k) = 1 V
V1 supply 0 2
R1 supply out 1k
R2 out 0 1k
.op
.end
