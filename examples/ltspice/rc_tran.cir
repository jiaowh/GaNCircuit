* Known answer: v(out) = 1 - exp(-t/RC), RC = 1 ms, for a 1 ns input step
V1 in 0 PULSE(0 1 0 1n 1n 1 2)
R1 in out 1k
C1 out 0 1u
.tran 0 5m 0 1u
.meas tran vtau FIND V(out) AT 1m
.end
