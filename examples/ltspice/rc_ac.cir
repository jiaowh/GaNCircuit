* Known answer: at f = 1/(2*pi*RC), |v(out)| = 1/sqrt(2) and phase = -45 deg
V1 in 0 AC 1
R1 in out 1k
C1 out 0 1u
.ac list 159.15494309189535 1 1meg
.end
